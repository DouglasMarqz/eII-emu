* EII VCA2: control current vs ACV (DC), small-signal gain, THD at 40 mVpp
.include ssm2045_m2.lib
.include eii_board.inc
.control
foreach a 0 0.2 0.25 0.3 0.4 0.5 0.75 1 2 3 4 5
 alter Vacv dc=$a
 op
 echo "VCADC acv=$a i15=$&v(x.vv2)" >> eii_vca.out
end
alter Vacv dc=5
alter Vin12 sin = [ 0 0.02 1000 ]
tran 2u 20m 0 2u
fourier 1000 v(cout)
alter Vin12 sin = [ 0 0.002 1000 ]
tran 2u 20m 0 2u
fourier 1000 v(cout)
.endc
.end
