* Fig.2 output noise (transistor shot noise of the reference), V5=-90 mV (wide open) and 0
.include ssm2045_m2.lib
Vcc 18 0 15
Vee 10 0 -6.8
Vin in 0 dc 0 ac 1
Rs  in 2 5k
V5  5 0 -0.09
C1 3 0 10n
C2 4 0 3.3n
C3 6 0 10n
C4 7 0 680p
RL1 1 0 10.91k
RL8 8 0 10.91k
Rq 17 0 1e9
R11 11 0 910
R12 12 0 910
R13 13 0 200
R14 14 0 1
R15 15 0 1e9
R16 16 0 1e9
X 1 2 3 4 5 6 7 8 0 10 11 12 13 14 15 16 17 18 SSM2045M2
.options temp=25 tnom=25
.control
foreach v -0.09 0
 alter V5 dc=$v
 noise v(8) Vin dec 50 20 20k
 setplot noise2
 echo "NOISE v5=$v onoise_total=$&onoise_total inoise_total=$&inoise_total"
 setplot noise1
 print v(onoise_spectrum)[50]
end
.endc
.end
